*** SPICE deck for cell Bitcell{sch} from library ESE3700_Project2
*** Created on Sun Apr 12, 2026 19:02:21
*** Last revised on Wed Apr 22, 2026 01:19:31
*** Written on Wed Apr 22, 2026 01:19:47 by Electric VLSI Design System, version 9.08
*** Layout tech: mocmos, foundry MOSIS
*** UC SPICE *** , MIN_RESIST 4.0, MIN_CAPAC 0.1FF
* Model cards described in this file:
.include C:\Users\lkkri\ESE3700-Lucas-Krippendorff\22nm_HP.pm

.global gnd vdd

*** TOP LEVEL CELL: Bitcell{sch}
Mnmos@0 net@35 net@3 gnd gnd N L=0.022U W=0.088U
Mnmos@1 net@3 net@35 gnd gnd N L=0.022U W=0.088U
Mnmos@3 net@35 WL BL gnd N L=0.022U W=0.044U
Mnmos@4 BLb WL net@3 gnd N L=0.022U W=0.044U
Mpmos@0 vdd net@3 net@35 vdd P L=0.022U W=0.022U
Mpmos@1 vdd net@35 net@3 vdd P L=0.022U W=0.022U
.END
